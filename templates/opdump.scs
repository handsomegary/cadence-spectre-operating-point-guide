simulator lang=spectre
opDump info what=oppoint where=file file="../psf/oppoint.lis"
